* SPDX-License-Identifier: Apache-2.0
* Abstract LVS pin interface derived from the official IHP SRAM LEF.
* Contiguous descending bus order lets Netgen infer full vector widths.
.SUBCKT RM_IHPSG13_1P_256x16_c2_bm_bist
+ A_ADDR[7] A_ADDR[6] A_ADDR[5] A_ADDR[4] A_ADDR[3] A_ADDR[2] A_ADDR[1] A_ADDR[0]
+ A_BIST_ADDR[7] A_BIST_ADDR[6] A_BIST_ADDR[5] A_BIST_ADDR[4] A_BIST_ADDR[3] A_BIST_ADDR[2] A_BIST_ADDR[1] A_BIST_ADDR[0]
+ A_BIST_BM[15] A_BIST_BM[14] A_BIST_BM[13] A_BIST_BM[12] A_BIST_BM[11] A_BIST_BM[10] A_BIST_BM[9] A_BIST_BM[8]
+ A_BIST_BM[7] A_BIST_BM[6] A_BIST_BM[5] A_BIST_BM[4] A_BIST_BM[3] A_BIST_BM[2] A_BIST_BM[1] A_BIST_BM[0]
+ A_BIST_CLK A_BIST_DIN[15] A_BIST_DIN[14] A_BIST_DIN[13] A_BIST_DIN[12] A_BIST_DIN[11] A_BIST_DIN[10] A_BIST_DIN[9]
+ A_BIST_DIN[8] A_BIST_DIN[7] A_BIST_DIN[6] A_BIST_DIN[5] A_BIST_DIN[4] A_BIST_DIN[3] A_BIST_DIN[2] A_BIST_DIN[1]
+ A_BIST_DIN[0] A_BIST_EN A_BIST_MEN A_BIST_REN A_BIST_WEN A_BM[15] A_BM[14] A_BM[13]
+ A_BM[12] A_BM[11] A_BM[10] A_BM[9] A_BM[8] A_BM[7] A_BM[6] A_BM[5]
+ A_BM[4] A_BM[3] A_BM[2] A_BM[1] A_BM[0] A_CLK A_DIN[15] A_DIN[14]
+ A_DIN[13] A_DIN[12] A_DIN[11] A_DIN[10] A_DIN[9] A_DIN[8] A_DIN[7] A_DIN[6]
+ A_DIN[5] A_DIN[4] A_DIN[3] A_DIN[2] A_DIN[1] A_DIN[0] A_DLY A_DOUT[15]
+ A_DOUT[14] A_DOUT[13] A_DOUT[12] A_DOUT[11] A_DOUT[10] A_DOUT[9] A_DOUT[8] A_DOUT[7]
+ A_DOUT[6] A_DOUT[5] A_DOUT[4] A_DOUT[3] A_DOUT[2] A_DOUT[1] A_DOUT[0] A_MEN
+ A_REN A_WEN VDD! VDDARRAY! VSS!
.ENDS RM_IHPSG13_1P_256x16_c2_bm_bist
